ADE simulation setup
Run mode: Single Run, Sweeps and Corners
Tests:
  FinalProjectLibrary_NAND_Circuit_1: FinalProjectLibrary/NAND_Circuit/schematic, simulator spectre
