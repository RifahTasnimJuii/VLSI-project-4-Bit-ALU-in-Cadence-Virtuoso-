ADE simulation setup
Run mode: Single Run, Sweeps and Corners
Tests:
  FinalProjectLibrary_AND4_Circuit_1: FinalProjectLibrary/AND4_Circuit/schematic, simulator spectre
