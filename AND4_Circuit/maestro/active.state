ADE simulation setup
Test FinalProjectLibrary_AND4_Circuit_1: FinalProjectLibrary/AND4_Circuit/schematic, simulator spectre
  Models: /home/cadence/tech/gpdk045_v_6_0/gpdk045/../models/spectre/gpdk045.scs[mc]
  Temperature: 27
  Analysis tran: stop=80n
  Signals: /net8, /net7, /net6, /net5, /net4, /net3, /net2, /net1, /Y0, /Y1, /Y2, /Y3
Run mode: Single Run, Sweeps and Corners
