ADE simulation setup
Test FinalProjectLibrary_FLAG_Circuit_1: FinalProjectLibrary/FLAG_Circuit/schematic, simulator spectre
  Models: /home/cadence/tech/gpdk045_v_6_0/gpdk045/../models/spectre/gpdk045.scs[mc]
  Temperature: 27
  Analysis tran: stop=80n
  Signals: /net3, /net1, /net2, /Y
Run mode: Single Run, Sweeps and Corners
