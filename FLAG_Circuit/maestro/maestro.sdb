ADE simulation setup
Run mode: Single Run, Sweeps and Corners
Tests:
  FinalProjectLibrary_FLAG_Circuit_1: FinalProjectLibrary/FLAG_Circuit/schematic, simulator spectre
