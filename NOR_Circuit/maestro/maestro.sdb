ADE simulation setup
Run mode: Single Run, Sweeps and Corners
Tests:
  FinalProjectLibrary_NOR_Circuit_1: FinalProjectLibrary/NOR_Circuit/schematic, simulator spectre
