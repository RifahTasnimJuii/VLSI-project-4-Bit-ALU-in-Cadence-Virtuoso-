ADE simulation setup
Test FinalProjectLibrary_NOR_Circuit_1: FinalProjectLibrary/NOR_Circuit/schematic, simulator spectre
  Models: /home/cadence/tech/gpdk045_v_6_0/gpdk045/../models/spectre/gpdk045.scs[mc]
  Temperature: 27
  Analysis tran: stop=120n
  Signals: /A, /B, /Y
Run mode: Single Run, Sweeps and Corners
