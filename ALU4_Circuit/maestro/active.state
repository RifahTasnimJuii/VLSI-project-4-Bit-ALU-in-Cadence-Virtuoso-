ADE simulation setup
Test FinalProjectLibrary_ALU4_Circuit_1: FinalProjectLibrary/ALU4_Circuit/schematic, simulator spectre
  Models: /home/cadence/tech/gpdk045_v_6_0/gpdk045/../models/spectre/gpdk045.scs[mc]
  Temperature: 27
  Analysis tran: stop=400n
  Output Avg_Power = (abs(average(IT("/V0/PLUS"))) * 1.8)
  Signals: /net1, /net2, /net7, /net8, /net9, /net10, /net3, /net4, /net5, /net6, /net11, /net12, /net13, /net14, /net15, /V0/PLUS (terminal)
Run mode: Single Run, Sweeps and Corners
