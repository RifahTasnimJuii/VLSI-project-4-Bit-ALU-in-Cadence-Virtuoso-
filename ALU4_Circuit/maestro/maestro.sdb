ADE simulation setup
Run mode: Single Run, Sweeps and Corners
Tests:
  FinalProjectLibrary_ALU4_Circuit_1: FinalProjectLibrary/ALU4_Circuit/schematic, simulator spectre
    Outputs: Avg_Power
