ADE simulation setup
Run mode: Single Run, Sweeps and Corners
Tests:
  FinalProjectLibrary_OR_Circuit_1: FinalProjectLibrary/OR_Circuit/schematic, simulator spectre
