ADE simulation setup
Run mode: Single Run, Sweeps and Corners
Tests:
  FinalProjectLibrary_OR4_Circuit_1: FinalProjectLibrary/OR4_Circuit/schematic, simulator spectre
