ADE simulation setup
Run mode: Single Run, Sweeps and Corners
Tests:
  FinalProjectLibrary_AND_Circuit_1: FinalProjectLibrary/AND_Circuit/schematic, simulator spectre
