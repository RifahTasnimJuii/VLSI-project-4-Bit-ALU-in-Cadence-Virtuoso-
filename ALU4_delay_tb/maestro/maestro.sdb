ADE simulation setup
Run mode: Single Run, Sweeps and Corners
Tests:
  FinalProjectLibrary_ALU4_delay_tb_1: FinalProjectLibrary/ALU4_delay_tb/schematic, simulator spectre
    Outputs: tpd_FLAG; tpd_R3
