ADE simulation setup
Test FinalProjectLibrary_ALU4_delay_tb_1: FinalProjectLibrary/ALU4_delay_tb/schematic, simulator spectre
  Models: /home/cadence/tech/gpdk045_v_6_0/gpdk045/../models/spectre/gpdk045.scs[mc]
  Temperature: 27
  Analysis tran: stop=20n
  Output tpd_FLAG = (cross(VT("/net15") 0.9 1 "rising") - cross(VT("/net22") 0.9 1 "rising"))
  Output tpd_R3 = (cross(VT("/net11") 0.9 1 "falling") - cross(VT("/net22") 0.9 1 "rising"))
  Signals: /net22, /net11, /net12, /net13, /net14, /net15
Run mode: Single Run, Sweeps and Corners
