ADE simulation setup
Run mode: Single Run, Sweeps and Corners
Tests:
  FinalProjectLibrary_inverter_test_1: FinalProjectLibrary/inverter_test/schematic, simulator spectre
