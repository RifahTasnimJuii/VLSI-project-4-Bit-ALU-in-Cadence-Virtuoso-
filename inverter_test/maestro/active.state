ADE simulation setup
Test FinalProjectLibrary_inverter_test_1: FinalProjectLibrary/inverter_test/schematic, simulator spectre
  Models: /home/cadence/tech/gpdk045_v_6_0/gpdk045/../models/spectre/gpdk045.scs[mc]
  Temperature: 27
  Analysis tran: stop=120n
  Signals: /A, /Y
Run mode: Single Run, Sweeps and Corners
