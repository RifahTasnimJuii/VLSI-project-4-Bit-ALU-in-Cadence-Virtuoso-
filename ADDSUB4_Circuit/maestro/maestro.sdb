ADE simulation setup
Run mode: Single Run, Sweeps and Corners
Tests:
  FinalProjectLibrary_ADDSUB4_Circuit_1: FinalProjectLibrary/ADDSUB4_Circuit/schematic, simulator spectre
