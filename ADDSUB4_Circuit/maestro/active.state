ADE simulation setup
Test FinalProjectLibrary_ADDSUB4_Circuit_1: FinalProjectLibrary/ADDSUB4_Circuit/schematic, simulator spectre
  Models: /home/cadence/tech/gpdk045_v_6_0/gpdk045/../models/spectre/gpdk045.scs[mc]
  Temperature: 27
  Analysis tran: stop=80n
  Signals: /M, /A3, /A2, /A1, /A0, /gnd!, /B2, /B1, /B0, /S3, /S2, /S1, /S0, /C4
Run mode: Single Run, Sweeps and Corners
