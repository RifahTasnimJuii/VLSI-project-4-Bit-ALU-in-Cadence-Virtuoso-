ADE simulation setup
Test FinalProjectLibrary_2x1MUX_Circuit_1: FinalProjectLibrary/2x1MUX_Circuit/schematic, simulator spectre
  Models: /home/cadence/tech/gpdk045_v_6_0/gpdk045/../models/spectre/gpdk045.scs[mc]
  Temperature: 27
  Analysis tran: stop=120n
  Signals: /IN0, /IN1, /S, /Y
Run mode: Single Run, Sweeps and Corners
