ADE simulation setup
Run mode: Single Run, Sweeps and Corners
Tests:
  FinalProjectLibrary_2x1MUX_Circuit_1: FinalProjectLibrary/2x1MUX_Circuit/schematic, simulator spectre
