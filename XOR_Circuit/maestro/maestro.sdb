ADE simulation setup
Run mode: Single Run, Sweeps and Corners
Tests:
  FinalProjectLibrary_XOR_Circuit_1: FinalProjectLibrary/XOR_Circuit/schematic, simulator spectre
