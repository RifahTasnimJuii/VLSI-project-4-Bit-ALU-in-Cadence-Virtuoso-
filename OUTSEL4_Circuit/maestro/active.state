ADE simulation setup
Test FinalProjectLibrary_OUTSEL4_Circuit_1: FinalProjectLibrary/OUTSEL4_Circuit/schematic, simulator spectre
  Models: /home/cadence/tech/gpdk045_v_6_0/gpdk045/../models/spectre/gpdk045.scs[mc]
  Temperature: 27
  Analysis tran: stop=80n
  Signals: /net25, /net10, /R3, /R2, /R1, /R0
Run mode: Single Run, Sweeps and Corners
