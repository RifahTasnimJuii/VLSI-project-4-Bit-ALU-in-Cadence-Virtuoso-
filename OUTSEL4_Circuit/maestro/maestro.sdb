ADE simulation setup
Run mode: Single Run, Sweeps and Corners
Tests:
  FinalProjectLibrary_OUTSEL4_Circuit_1: FinalProjectLibrary/OUTSEL4_Circuit/schematic, simulator spectre
