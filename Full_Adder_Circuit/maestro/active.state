ADE simulation setup
Test FinalProjectLibrary_Full_Adder_Circuit_1: FinalProjectLibrary/Full_Adder_Circuit/schematic, simulator spectre
  Models: /home/cadence/tech/gpdk045_v_6_0/gpdk045/../models/spectre/gpdk045.scs[mc]
  Temperature: 27
  Analysis tran: stop=120n
  Signals: /A, /B, /Cin, /S, /Y
Run mode: Single Run, Sweeps and Corners
