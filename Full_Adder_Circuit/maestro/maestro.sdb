ADE simulation setup
Run mode: Single Run, Sweeps and Corners
Tests:
  FinalProjectLibrary_Full_Adder_Circuit_1: FinalProjectLibrary/Full_Adder_Circuit/schematic, simulator spectre
